//
// Generated by Semifore, Inc. csrCompile
//   Version: 2009.01
//   Released on: Mar 12 2009 21:24:47
//   SystemRDL output
//
// Input files:
//    dma.xml
//
// Generated on: Mon Mar 16 11:48:27 2009
//           by: weber
//
//  Revision:    $Revision:$
//  Date:        $Date:$
//
//  Copyright (c) 2009 The SPIRIT Consortium.
//
//  This work forms part of a deliverable of The SPIRIT Consortium.
//
//  Use of these materials are governed by the legal terms and conditions
//  outlined in the disclaimer available from www.spiritconsortium.org.
//
//  This source file is provided on an AS IS basis.  The SPIRIT
//  Consortium disclaims any warranty express or implied including
//  any warranty of merchantability and fitness for use for a
//  particular purpose.
//
//  The user of the source file shall indemnify and hold The SPIRIT
//  Consortium and its members harmless from any damages or liability.
//  Users are requested to provide feedback to The SPIRIT Consortium
//  using either mailto:feedback@lists.spiritconsortium.org or the forms at
//  http://www.spiritconsortium.org/about/contact_us/
//
//  This file may be copied, and distributed, with or without
//  modifications; this notice must be included on any copy.
//
addrmap dma {
   reg {
      name = "sourceAddress";
      field {
         name = "sourceAddress";
         sw = rw;
         hw = r;
      } sourceAddress[31:0];
   } sourceAddress @0x0;
   reg {
      name = "destinationAddress";
      field {
         name = "destinationAddress";
         sw = rw;
         hw = r;
      } destinationAddress[31:0];
   } destinationAddress @0x4;
   reg {
      name = "control";
      field {
         name = "control";
         desc = "Size of data transfer";
         sw = rw;
         hw = r;
      } length[7:0];
      field {
         name = "control";
         desc = "00=no incrment, 01=Byte, 01=half word, 11=Word incrementing of address";
         sw = rw;
         hw = r;
      } sourceIncrement[9:8];
      field {
         name = "control";
         desc = "00=no incrment, 01=Byte, 01=half word, 11=Word incrementing of address";
         sw = rw;
         hw = r;
      } destinationIncrement[11:10];
      field {
         name = "control";
         desc = "Enable transfer";
         sw = w;
         hw = r;
      } \enable [12:12];
   } control @0x8;
};
