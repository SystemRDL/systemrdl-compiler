//
// Generated by Semifore, Inc. csrCompile
//   Version: 2009.01
//   Released on: Mar 25 2009 13:10:07
//   SystemRDL output
//
// Input files:
//    rgu.xml
//
// Generated on: Thu Mar 26 22:01:35 2009
//           by: weber
//
//  Revision:    $Revision:$
//  Date:        $Date:$
//
//  Copyright (c) 2009 The SPIRIT Consortium.
//
//  This work forms part of a deliverable of The SPIRIT Consortium.
//
//  Use of these materials are governed by the legal terms and conditions
//  outlined in the disclaimer available from www.spiritconsortium.org.
//
//  This source file is provided on an AS IS basis.  The SPIRIT
//  Consortium disclaims any warranty express or implied including
//  any warranty of merchantability and fitness for use for a
//  particular purpose.
//
//  The user of the source file shall indemnify and hold The SPIRIT
//  Consortium and its members harmless from any damages or liability.
//  Users are requested to provide feedback to The SPIRIT Consortium
//  using either mailto:feedback@lists.spiritconsortium.org or the forms at
//  http://www.spiritconsortium.org/about/contact_us/
//
//  This file may be copied, and distributed, with or without
//  modifications; this notice must be included on any copy.
//
addrmap ambaAPB {
   regfile {
      reg {
         field {
            desc = "Delay value for reset 0, 0=no delay, 1=delay by 1 ipclk, 2=delay by 2 ipclk, ...";
            sw = r;
            hw = na;
            reset = 8'h0;
         } delay[7:0];
         field {
            desc = "Reserved";
            sw = r;
            hw = na;
            reset = 24'h0;
         } Reserved[31:8];
      } reset0Delay @0x0;
      reg {
         field {
            desc = "Delay value for reset 1, 0=no delay, 1=delay by 1 ipclk, 2=delay by 2 ipclk, ...";
            sw = r;
            hw = na;
            reset = 8'h1;
         } delay[7:0];
         field {
            desc = "Reserved";
            sw = r;
            hw = na;
            reset = 24'h0;
         } Reserved[31:8];
      } reset1Delay @0x4;
      reg {
         field {
            desc = "Delay value for reset 2, 0=no delay, 1=delay by 1 ipclk, 2=delay by 2 ipclk, ...";
            sw = r;
            hw = na;
            reset = 8'h2;
         } delay[7:0];
         field {
            desc = "Reserved";
            sw = r;
            hw = na;
            reset = 24'h0;
         } Reserved[31:8];
      } reset2Delay @0x8;
      reg {
         field {
            desc = "Delay value for reset 3, 0=no delay, 1=delay by 1 ipclk, 2=delay by 2 ipclk, ...";
            sw = r;
            hw = na;
            reset = 8'h4;
         } delay[7:0];
         field {
            desc = "Reserved";
            sw = r;
            hw = na;
            reset = 24'h0;
         } Reserved[31:8];
      } reset3Delay @0xc;
      reg {
         field {
            desc = "Delay value for reset 4, 0=no delay, 1=delay by 1 ipclk, 2=delay by 2 ipclk, ...";
            sw = r;
            hw = na;
            reset = 8'h8;
         } delay[7:0];
         field {
            desc = "Reserved";
            sw = r;
            hw = na;
            reset = 24'h0;
         } Reserved[31:8];
      } reset4Delay @0x10;
      reg {
         field {
            desc = "Delay value for reset 5, 0=no delay, 1=delay by 1 ipclk, 2=delay by 2 ipclk, ...";
            sw = r;
            hw = na;
            reset = 8'h10;
         } delay[7:0];
         field {
            desc = "Reserved";
            sw = r;
            hw = na;
            reset = 24'h0;
         } Reserved[31:8];
      } reset5Delay @0x14;
      reg {
         field {
            desc = "Delay value for reset 6, 0=no delay, 1=delay by 1 ipclk, 2=delay by 2 ipclk, ...";
            sw = r;
            hw = na;
            reset = 8'h20;
         } delay[7:0];
         field {
            desc = "Reserved";
            sw = r;
            hw = na;
            reset = 24'h0;
         } Reserved[31:8];
      } reset6Delay @0x18;
      reg {
         field {
            desc = "Delay value for reset 7, 0=no delay, 1=delay by 1 ipclk, 2=delay by 2 ipclk, ...";
            sw = r;
            hw = na;
            reset = 8'h40;
         } delay[7:0];
         field {
            desc = "Reserved";
            sw = r;
            hw = na;
            reset = 24'h0;
         } Reserved[31:8];
      } reset7Delay @0x1c;
   } resetDelays @0x0;
   regfile {
      reg {
         field {
            desc = "Scratch memory, EEPROM";
            sw = rw;
            hw = r;
            reset = 32'h0;
         } data[31:0];
      } eeprom[8] @0x0;
   } EEPROM @0x20;
   // external reg {
   // } Reserved[1007] @0x40;
   regfile {
      reg {
         desc = "ID register";
         field {
            desc = "ID Field";
            sw = r;
            hw = na;
            reset = 32'hd01;
         } ID[31:0];
      } IDReg @0x0;
   } idAddressBlock @0xffc;
};
