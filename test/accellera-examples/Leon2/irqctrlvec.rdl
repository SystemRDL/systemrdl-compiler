//
// Generated by Semifore, Inc. csrCompile
//   Version: 2009.01
//   Released on: Mar 16 2009 13:12:10
//   SystemRDL output
//
// Input files:
//    irqctrlvec.xml
//
// Generated on: Mon Mar 16 14:32:03 2009
//           by: weber
//
//  Revision:    $Revision:$
//  Date:        $Date:$
//
//  Copyright (c) 2009 The SPIRIT Consortium.
//
//  This work forms part of a deliverable of The SPIRIT Consortium.
//
//  Use of these materials are governed by the legal terms and conditions
//  outlined in the disclaimer available from www.spiritconsortium.org.
//
//  This source file is provided on an AS IS basis.  The SPIRIT
//  Consortium disclaims any warranty express or implied including
//  any warranty of merchantability and fitness for use for a
//  particular purpose.
//
//  The user of the source file shall indemnify and hold The SPIRIT
//  Consortium and its members harmless from any damages or liability.
//  Users are requested to provide feedback to The SPIRIT Consortium
//  using either mailto:feedback@lists.spiritconsortium.org or the forms at
//  http://www.spiritconsortium.org/about/contact_us/
//
//  This file may be copied, and distributed, with or without
//  modifications; this notice must be included on any copy.
//
addrmap irqctrlvec {
   reg {
      desc = "Interrupt Mask and Priority";
      field {
         desc = "Reserved";
         sw = rw;
         hw = r;
      } Reserved1[0:0];
      field {
         desc = "Indicates if an interrupt is masked (bit=0) or enabled (bit=1)";
         sw = rw;
         hw = r;
         reset = 15'h0;
      } imask[15:1];
      field {
         desc = "Reserved";
         sw = rw;
         hw = r;
      } Reserved2[16:16];
      field {
         desc = "Indicates if an interrupt belongs to priority level 1 (bit=1) or 0 (bit=0)";
         sw = rw;
         hw = r;
      } ilevel[31:17];
   } interrupMaskandPriorityLevel @0x0;
   reg {
      desc = "Indicates if an interrupt is pending";
      field {
         desc = "Reserved";
         sw = rw;
         hw = r;
      } Reserved1[0:0];
      field {
         desc = "Indicates if an interrupt is pending (bit=1)";
         sw = rw;
         hw = r;
      } ipend[15:1];
      field {
         desc = "Reserved";
         sw = rw;
         hw = r;
      } Reserved2[31:16];
   } interruptPendingRegister @0x4;
   reg {
      desc = "Indicates if an interrupt is being forced";
      field {
         desc = "Reserved";
         sw = rw;
         hw = r;
      } Reserved1[0:0];
      field {
         desc = "Indicates if an interrupt is being forced (bit=1)";
         sw = rw;
         hw = r;
      } iforce[15:1];
      field {
         desc = "Reserved";
         sw = rw;
         hw = r;
      } Reserved2[31:16];
   } interruptForceRegister @0x8;
   reg {
      desc = "If written with a '1', will clear corresponding bit(s) in interrupt pending register. A read returns 0.";
      field {
         desc = "Reserved";
         sw = rw;
         hw = r;
      } Reserved1[0:0];
      field {
         desc = "If written with a '1', will clear corresponding bit(s) in interrupt pending register. A read returns 0.";
         sw = rw;
         hw = r;
      } iforce[15:1];
      field {
         desc = "Reserved";
         sw = rw;
         hw = r;
      } Reserved2[31:16];
   } interruptClearRegister @0xc;
   reg {
      desc = "interruptReadClearPendingRegister";
      field {
         desc = "interruptReadClearPendingRegister";
         sw = rw;
         hw = r;
      } interruptReadClearPendingRegister[31:0];
   } interruptReadClearPendingRegister @0x10;
};
