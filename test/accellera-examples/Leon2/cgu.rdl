//
// Generated by Semifore, Inc. csrCompile
//   Version: 2009.01
//   Released on: Mar 16 2009 13:12:10
//   SystemRDL output
//
// Input files:
//    cgu.xml
//
// Generated on: Tue Mar 17 13:41:18 2009
//           by: weber
//
//  Revision:    $Revision:$
//  Date:        $Date:$
//
//  Copyright (c) 2009 The SPIRIT Consortium.
//
//  This work forms part of a deliverable of The SPIRIT Consortium.
//
//  Use of these materials are governed by the legal terms and conditions
//  outlined in the disclaimer available from www.spiritconsortium.org.
//
//  This source file is provided on an AS IS basis.  The SPIRIT
//  Consortium disclaims any warranty express or implied including
//  any warranty of merchantability and fitness for use for a
//  particular purpose.
//
//  The user of the source file shall indemnify and hold The SPIRIT
//  Consortium and its members harmless from any damages or liability.
//  Users are requested to provide feedback to The SPIRIT Consortium
//  using either mailto:feedback@lists.spiritconsortium.org or the forms at
//  http://www.spiritconsortium.org/about/contact_us/
//
//  This file may be copied, and distributed, with or without
//  modifications; this notice must be included on any copy.
//
addrmap cgu {
   reg {
      field {
         desc = "Divide value for clock 0, 0=no divide, 1=divide by 2, 2=divide by 4, 3=divide by 6, ...";
         sw = rw;
         hw = r;
         reset = 8'h0;
      } divide[7:0];
      field {
         desc = "Reserved";
         sw = r;
         hw = na;
         reset = 24'h0;
      } Reserved[31:8];
   } clock0Divide @0x0;
   reg {
      field {
         desc = "Divide value for clock 1, 0=no divide, 1=divide by 2, 2=divide by 4, 3=divide by 6, ...";
         sw = rw;
         hw = r;
         reset = 8'h0;
      } divide[7:0];
      field {
         desc = "Reserved";
         sw = r;
         hw = na;
         reset = 24'h0;
      } Reserved[31:8];
   } clock1Divide @0x4;
   reg {
      field {
         desc = "Divide value for clock 2, 0=no divide, 1=divide by 2, 2=divide by 4, 3=divide by 6, ...";
         sw = rw;
         hw = r;
         reset = 8'h0;
      } divide[7:0];
      field {
         desc = "Reserved";
         sw = r;
         hw = na;
         reset = 24'h0;
      } Reserved[31:8];
   } clock2Divide @0x8;
   reg {
      field {
         desc = "Divide value for clock 3, 0=no divide, 1=divide by 2, 2=divide by 4, 3=divide by 6, ...";
         sw = rw;
         hw = r;
         reset = 8'h0;
      } divide[7:0];
      field {
         desc = "Reserved";
         sw = r;
         hw = na;
         reset = 24'h0;
      } Reserved[31:8];
   } clock3Divide @0xc;
   reg {
      field {
         desc = "Divide value for clock 4, 0=no divide, 1=divide by 2, 2=divide by 4, 3=divide by 6, ...";
         sw = rw;
         hw = r;
         reset = 8'h0;
      } divide[7:0];
      field {
         desc = "Reserved";
         sw = r;
         hw = na;
         reset = 24'h0;
      } Reserved[31:8];
   } clock4Divide @0x10;
   reg {
      field {
         desc = "Divide value for clock 5, 0=no divide, 1=divide by 2, 2=divide by 4, 3=divide by 6, ...";
         sw = rw;
         hw = r;
         reset = 8'h0;
      } divide[7:0];
      field {
         desc = "Reserved";
         sw = r;
         hw = na;
         reset = 24'h0;
      } Reserved[31:8];
   } clock5Divide @0x14;
   reg {
      field {
         desc = "Divide value for clock 6, 0=no divide, 1=divide by 2, 2=divide by 4, 3=divide by 6, ...";
         sw = rw;
         hw = r;
         reset = 8'h0;
      } divide[7:0];
      field {
         desc = "Reserved";
         sw = r;
         hw = na;
         reset = 24'h0;
      } Reserved[31:8];
   } clock6Divide @0x18;
   reg {
      field {
         desc = "Divide value for clock 7, 0=no divide, 1=divide by 2, 2=divide by 4, 3=divide by 6, ...";
         sw = rw;
         hw = r;
         reset = 8'h0;
      } divide[7:0];
      field {
         desc = "Reserved";
         sw = r;
         hw = na;
         reset = 24'h0;
      } Reserved[31:8];
   } clock7Divide @0x1c;
   reg {
      desc = "ID register";
      field {
         desc = "ID Field";
         sw = r;
         hw = w;
         reset = 32'hd00;
      } ID[31:0];
   } IDReg @0xffc;
};
