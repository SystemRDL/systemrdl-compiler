//
// Generated by Semifore, Inc. csrCompile
//   Version: 2009.01
//   Released on: Mar 16 2009 13:12:10
//   SystemRDL output
//
// Input files:
//    i2c_gpio_addr.xml
//
// Generated on: Tue Mar 17 15:02:15 2009
//           by: weber
//
//  Revision:    $Revision:$
//  Date:        $Date:$
//
//  Copyright (c) 2009 The SPIRIT Consortium.
//
//  This work forms part of a deliverable of The SPIRIT Consortium.
//
//  Use of these materials are governed by the legal terms and conditions
//  outlined in the disclaimer available from www.spiritconsortium.org.
//
//  This source file is provided on an AS IS basis.  The SPIRIT
//  Consortium disclaims any warranty express or implied including
//  any warranty of merchantability and fitness for use for a
//  particular purpose.
//
//  The user of the source file shall indemnify and hold The SPIRIT
//  Consortium and its members harmless from any damages or liability.
//  Users are requested to provide feedback to The SPIRIT Consortium
//  using either mailto:feedback@lists.spiritconsortium.org or the forms at
//  http://www.spiritconsortium.org/about/contact_us/
//
//  This file may be copied, and distributed, with or without
//  modifications; this notice must be included on any copy.
//
addrmap i2c_gpio_addr {
   default regwidth = 8;
   reg {
      field {
         sw = r;
         hw = w;
      } inputreg_field[3:0];
   } inputreg @0x0;
   reg {
      field {
         sw = rw;
         hw = r;
         reset = 4'h0;
      } outputreg_field[3:0];
   } outputreg @0x1;
};
