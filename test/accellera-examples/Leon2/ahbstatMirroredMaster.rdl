//
// Generated by Semifore, Inc. csrCompile
//   Version: 2009.01
//   Released on: Mar 16 2009 13:12:10
//   SystemRDL output
//
// Input files:
//    ahbstatMirroredMaster.xml
//
// Generated on: Mon Mar 16 16:13:38 2009
//           by: weber
//
//  Revision:    $Revision:$
//  Date:        $Date:$
//
//  Copyright (c) 2009 The SPIRIT Consortium.
//
//  This work forms part of a deliverable of The SPIRIT Consortium.
//
//  Use of these materials are governed by the legal terms and conditions
//  outlined in the disclaimer available from www.spiritconsortium.org.
//
//  This source file is provided on an AS IS basis.  The SPIRIT
//  Consortium disclaims any warranty express or implied including
//  any warranty of merchantability and fitness for use for a
//  particular purpose.
//
//  The user of the source file shall indemnify and hold The SPIRIT
//  Consortium and its members harmless from any damages or liability.
//  Users are requested to provide feedback to The SPIRIT Consortium
//  using either mailto:feedback@lists.spiritconsortium.org or the forms at
//  http://www.spiritconsortium.org/about/contact_us/
//
//  This file may be copied, and distributed, with or without
//  modifications; this notice must be included on any copy.
//
addrmap ahbstatMirroredMaster {
   reg {
      desc = "This register is updated whenever and AHB error occurs. The newError bit is set. After an error, the newError bit has to be reset by software.";
      field {
         desc = "This field contains the HSIZE[2:0] of the failed transfer.";
         sw = rw;
         hw = r;
         reset = 3'h0;
      } hsize[2:0];
      field {
         desc = "This field contains the HMASTER[3:0] of the failed transfer, only if this connected to a slave or mirrored slave.";
         sw = rw;
         hw = r;
         reset = 4'h0;
      } hmaster[6:3];
      field {
         desc = "This bit is set if the failed access was a read cycle, otherwise it is cleared.";
         sw = rw;
         hw = r;
         reset = 1'h0;
      } \rw [7:7];
      field {
         desc = "Set when a new error occurred.";
         sw = rw;
         hw = r;
         reset = 1'h0;
      } newError[8:8];
      field {
         desc = "Reserved";
         sw = rw;
         hw = r;
      } reserved[31:9];
   } ahbStatus @0x0;
   reg {
      desc = "This register is updated whenever and AHB error occurs. The newError bit is set in register ahbStatus.";
      field {
         desc = "This field contains the HADDR[31:0] of the failed transfer.";
         sw = rw;
         hw = r;
         reset = 32'h0;
      } haddr[31:0];
   } ahbFailedAddress @0x4;
};
