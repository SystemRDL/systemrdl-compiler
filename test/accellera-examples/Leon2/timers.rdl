//
// Generated by Semifore, Inc. csrCompile
//   Version: 2009.01
//   Released on: Mar 18 2009 15:03:16
//   SystemRDL output
//
// Input files:
//    timers.xml
//
// Generated on: Fri Mar 20 09:48:13 2009
//           by: weber
//
//  Revision:    $Revision:$
//  Date:        $Date:$
//
//  Copyright (c) 2009 The SPIRIT Consortium.
//
//  This work forms part of a deliverable of The SPIRIT Consortium.
//
//  Use of these materials are governed by the legal terms and conditions
//  outlined in the disclaimer available from www.spiritconsortium.org.
//
//  This source file is provided on an AS IS basis.  The SPIRIT
//  Consortium disclaims any warranty express or implied including
//  any warranty of merchantability and fitness for use for a
//  particular purpose.
//
//  The user of the source file shall indemnify and hold The SPIRIT
//  Consortium and its members harmless from any damages or liability.
//  Users are requested to provide feedback to The SPIRIT Consortium
//  using either mailto:feedback@lists.spiritconsortium.org or the forms at
//  http://www.spiritconsortium.org/about/contact_us/
//
//  This file may be copied, and distributed, with or without
//  modifications; this notice must be included on any copy.
//
addrmap timers {
   reg {
      name = "timer1Counter";
      desc = "Timer 1 value";
      field {
         desc = "Value of Timer 1";
         sw = rw;
         hw = r;
      } timer1Value[23:0];
      field {
         desc = "Reserved";
         sw = rw;
         hw = r;
      } reserved[31:24];
   } timer1Counter @0x0;
   reg {
      name = "timer1Reload";
      desc = "Timer 1 Reload Value";
      field {
         desc = "Timer 1 Reload Value";
         sw = rw;
         hw = r;
      } timerReloadValue[23:0];
      field {
         desc = "Reserved";
         sw = rw;
         hw = r;
      } reserved[31:24];
   } timer1Reload @0x4;
   reg {
      name = "timer1Control";
      desc = "Timer 1 Control Register";
      field {
         desc = "Enables the timer when set.";
         sw = rw;
         hw = r;
         reset = 1'h0;
      } \enable [0:0];
      field {
         desc = "When set to 1 the counter will automatically be reloaded with the reload value after each underflow.";
         sw = rw;
         hw = r;
      } reloadCounter[1:1];
      field {
         desc = "When written with 1, will load the timer reload register into the timer counter register. Always reads as a 0.";
         sw = rw;
         hw = r;
      } loadCounter[2:2];
   } timer1Control @0x8;
   reg {
      name = "watchdogCounter";
      desc = "Watchdog 1 value";
      field {
         desc = "Watchdog 1 value";
         sw = rw;
         hw = r;
      } watchdogValue[23:0];
      field {
         desc = "Reserved";
         sw = rw;
         hw = r;
      } reserved[31:24];
   } watchdogCounter @0xc;
   reg {
      name = "timer2Counter";
      desc = "Timer 2 value";
      field {
         desc = "Timer 2 value";
         sw = rw;
         hw = r;
      } timer2Value[23:0];
      field {
         desc = "Reserved";
         sw = rw;
         hw = r;
      } reserved[31:24];
   } timer2Counter @0x10;
   reg {
      name = "timer2Reload";
      desc = "Timer 2 Reload Value";
      field {
         desc = "Timer 2 Reload Value";
         sw = rw;
         hw = r;
      } timerReloadValue[23:0];
      field {
         desc = "Reserved";
         sw = rw;
         hw = r;
      } reserved[31:24];
   } timer2Reload @0x14;
   reg {
      name = "timer2Control";
      desc = "Timer 2 Control Register";
      field {
         desc = "Enables the timer when set.";
         sw = rw;
         hw = r;
         reset = 1'h0;
      } \enable [0:0];
      field {
         desc = "When set to 1 the counter will automatically be reloaded with the reload value after each underflow.";
         sw = rw;
         hw = r;
      } reloadCounter[1:1];
      field {
         desc = "When written with 1, will load the timer reload register into the timer counter register. Always reads as a 0.";
         sw = rw;
         hw = r;
      } loadCounter[2:2];
   } timer2Control @0x18;
   reg {
      name = "prescalerCounter";
      desc = "Prescaler Counter";
      field {
         desc = "Prescaler Counter Value";
         sw = rw;
         hw = r;
      } reloadValue[9:0];
      field {
         desc = "Reserved";
         sw = rw;
         hw = r;
      } reserved[31:10];
   } prescalerCounter @0x20;
   reg {
      name = "prescalerReloadValue";
      desc = "Prescaler Reload Value";
      field {
         desc = "Prescaler Reload Value";
         sw = rw;
         hw = r;
      } reloadValue[9:0];
      field {
         desc = "Reserved";
         sw = rw;
         hw = r;
      } reserved[31:10];
   } prescalerReloadValue @0x24;
};
