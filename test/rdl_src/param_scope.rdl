addrmap param_scope {
    regfile rf_t #(
        longint N = 1
    ) {
        reg reg_t {
            field {} ff[N];
        };

        regfile rf2_t {
            reg_t rr;
        };

        regfile {
            rf2_t rf2;
        } rf3;
    };

    rf_t #(.N(2)) rfX;
    rf_t #(.N(3)) rfY;
    rf_t rfZ;
};
