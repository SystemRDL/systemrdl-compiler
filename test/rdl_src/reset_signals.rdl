default sw=rw;
default hw=r;

addrmap field_resets {
    signal {activehigh;} reset_x;
    signal {field_reset = false;} not_a_reset;

    regfile {
        signal {field_reset; activehigh;} reset_y;
        reg {
            signal {field_reset; activelow;} reset_z;

            field {} A = 0; // implied reset_z
            field {resetsignal = reset_x;} B = 0;
            field {resetsignal = reset_y;} C = 0;
        } x;

        reg {
            field {} A = 0; // implied reset_y
            field {resetsignal = reset_x;} B = 0;
        } y;
    } rf;

    reg {
        field {} A = 0; // No implied resetsignal
        field {resetsignal = reset_x;} B = 0;
    } z;
};


addrmap cpuif_resets {
    signal {cpuif_reset = false;} not_a_reset;
    regfile {
        signal {cpuif_reset; activehigh;} reset_x;
        reg {
            signal {cpuif_reset; activehigh;} reset_y;

            field {} A = 0;
        } x;

        reg {
            field {} A = 0;
        } y;
    } rf;

    reg {
        field {} A = 0; // No implied resetsignal
    } z;
};
