addrmap top {

  reg reg_t #(longint FIELD_WIDTH = 5) {
    field {} f[8+FIELD_WIDTH-1:8] = {FIELD_WIDTH{1'b1}};
  };

  reg_t r_default;
  reg_t #(.FIELD_WIDTH(4)) r_four;
  reg_t #(.FIELD_WIDTH(6)) r_six;
};
