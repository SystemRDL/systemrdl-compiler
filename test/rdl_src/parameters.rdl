
// From 5.1.2.1.2
mem fixed_mem #(longint unsigned word_size = 32,
    longint unsigned memory_size = word_size * 4096) {
    mementries = memory_size / word_size ;
    memwidth = word_size ;
};

// From 5.1.2.1.1
reg myReg #(longint unsigned SIZE = 32, boolean SHARED = true) {
    regwidth = SIZE;
    shared = SHARED;
    field {} data[SIZE - 1];
};

addrmap myAmap {
    myReg reg32;
    myReg reg32_arr[8];
    myReg #(.SIZE(16)) reg16;
    myReg #(.SIZE(8), .SHARED(false)) reg8;

    external fixed_mem mem32;
    external fixed_mem #(.word_size(64)) mem64;
};

//------------------------------------------------------------------------------

struct struct_t {
    boolean x;
    boolean a;
    string b;
    accesstype c;
    addressingtype d;
    longint e[];
};

reg struct_param_reg #(
    struct_t STRUCT_1 = struct_t'{},
    struct_t STRUCT_2 = struct_t'{},
    struct_t STRUCT_3 = struct_t'{},
    struct_t STRUCT_4 = struct_t'{}
){
    field {} data;
};

addrmap struct_param {
    struct_param_reg #(
        .STRUCT_2(struct_t'{}),
        .STRUCT_3(struct_t'{x: false}),
        .STRUCT_4(struct_t'{a: true})
    ) spr;
};
