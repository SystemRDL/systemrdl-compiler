
property ref_prop {
    component = all;
    type = ref;
};

signal {activehigh;} glbl_sig;

default resetsignal = glbl_sig;

reg my_reg {
    field {} x;

    signal {activehigh;} sig;

    default ref_prop = x;
    default resetsignal = sig;
    default next = x->anded;

    field my_field {};

    my_field y;
};

addrmap top {
    my_reg reg1;

    default ref_prop = reg1;

    my_reg reg2[2];

    default resetsignal = reg2[1].sig;
    default next = reg2[0].y->ored;

    field field_z {};

    reg {
        field_z z;
    } reg3;
};
