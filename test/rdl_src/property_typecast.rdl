enum test_e {
    VAL0 = 0;
    VAL1 = 1;
    VAL2 = 2;
    VAL3 = 3;
};

addrmap enum_cast {
    reg {
        field f_t {
            encode = test_e;
        };

        f_t f1[2];
        f_t f2[2];
        f_t f3[2];
        f_t f4[2];

        // Implicit cast to int
        f1->reset = test_e::VAL3;

        // implicit cast to bool
        f1->we = 100;
        f2->we = test_e::VAL1;
        f3->we = 0;
        f4->we = test_e::VAL0;
    } r1;
};