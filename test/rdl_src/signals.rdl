addrmap top {
    signal {
        signalwidth = 8;
    } s1;

    reg {
        signal {
            signalwidth = 6;
        } s1;
        field {
            signal {
                signalwidth = 4;
            } s1;
        } f1;
    } r1;
};
