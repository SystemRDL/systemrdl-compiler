addrmap interleaved_arrays_test {
    reg test { 
        field {
        sw = w;
        hw = rw;
        } f1;
    }; 
    test reg1[8] @ 0x00 += 0x08;
    test reg2[8] @ 0x04 += 0x08;
};

addrmap interleaved_arrays_test_2 {
    reg test { 
        field {
        sw = w;
        hw = rw;
        } f1;
    }; 
    test reg1[8] @ 0x20 += 0x40;
    test reg2[8] @ 0x24 += 0x40;
    test reg3 @ 0x28;
};
