addrmap top {
    reg {
        field {} a[32];
    } a;

    reg {
        field {} a[7:0];
        field {} b[15:8];
        field {} c[31:16];
    } b;

    reg {
        field {} a[7:1];
        field {} b[15:9];
        field {} c[30:17];
    } c;

    reg {
        field {} a[7:2];
        field {} b[15:10];
        field {} c[29:18];
    } d;

    reg {
        field ro_field {sw = r; hw = w;};
        field wo_field {sw = w; hw = r;};

        ro_field a[7:4];
        wo_field b[7:4];

        ro_field c[20:16];
        wo_field d[23:18];
    } e;
};
