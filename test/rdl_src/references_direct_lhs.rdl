property ref_prop {
    component = all;
    type = ref;
};


signal {activehigh;} glbl_sig;

reg my_reg {
    signal {activehigh;} sig;

    field {
        resetsignal = glbl_sig;
    } x;

    field {
        resetsignal = sig;
    } y;

    ref_prop = x;
};

addrmap top {
    my_reg reg1;
    my_reg reg2[2];

    ref_prop = reg2[1].x;
};
