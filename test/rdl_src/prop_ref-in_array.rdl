addrmap ref_in_array {
    reg {
        default sw = rw;
        default hw = rw;
        field {} a = 0;
        field {} b = 0;
        b->next = a->anded;
    } myreg[8];
};
