

reg my_reg #(bit MY_PARAM = 1) {
    field my_field {
        hw = rw;
        sw = rw;
        reset = 1 + 3;
    };
    
    
    my_field asdf[2] = 1;
    my_field foo = 1 / MY_PARAM + 0x100 - 16'd4;
    
};


addrmap my_design {
    my_reg reg_a[2];
    my_reg reg_b[3][2];
    my_reg #(
        .MY_PARAM(2)
    ) reg_c;
    
    signal {} sig_a;
    
    reg {
        field {} f_a;
        field {} f_b;
        
    } r_a[3];
    
    
};
