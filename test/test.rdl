

reg my_reg #(bit MY_PARAM = 1) {
    field my_field {
        hw = rw;
        sw = rw;
        reset = 1 + 3;
    };
    
    
    my_field asdf[2] = 1;
    my_field foo = 1 / MY_PARAM + 0x100 - 16'd4;
    
};


addrmap my_design {
    my_reg reg_a;
    my_reg reg_b;
    my_reg reg_c;

    signal {} sig_a;
    
};
