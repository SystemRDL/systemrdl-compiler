addrmap top {
    reg {
        field {} f[3:0];
    } my_reg[4];

    my_reg[0][0].f->reset = 0;
};
