addrmap err_missing_reset {
    reg {
        default sw = rw;
        default hw = rw;
        field {} a;
        field {} b;
        b->next = a->reset; // a's reset was never set
    }y;
};

addrmap err_circular_ref {
    reg {
        default sw = rw;
        default hw = rw;
        field {} a;
        field {} b;
        a->next = b->next;
        b->next = a->next;
    }y;
};

addrmap err_self_reset {
    reg {
        default sw = rw;
        default hw = rw;
        field {} a;
        a->reset = a;
    }y;
};

addrmap err_no_inferred {
    reg {
        default sw = rw;
        default hw = rw;
        field {} a;
        field {} b;
        b->next = a->we;
    }y;
};

addrmap err_not_a_counter {
    reg {
        default sw = rw;
        default hw = rw;
        field {} a;
        field {} b;
        b->next = a->incr;
    }y;
};

addrmap err_no_counter_threshold {
    reg {
        default sw = rw;
        default hw = rw;
        field {
            counter;
        } a;
        field {} b;
        field {} c;
        b->next = a->incrthreshold;
    }y;
};
