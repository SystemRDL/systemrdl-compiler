property a_map_p { type = string; component = addrmap | regfile; };
property some_bool_p { type = boolean; component = field; default = false; };
property some_ref_p { type = ref; component = all; };
property some_num_p { type = number; default = 0x10; component = field | reg | regfile; };

addrmap foo {
    reg{
        field { some_bool_p; } field1;  // Attach some_bool_p to the field
                                        // with a value of false;

        field { sw=rw; some_bool_p = true; some_num_p; } field2;
        // Attach some_bool_p to the field with a value of true;
        field1->some_ref_p = field2; // create a reference
        some_num_p = 0x20; // Assign this property to the reg and give it value
    } bar;

    a_map_p; // The property has been bound to the map but it has not been
            // assigned a value so its value is undefined
};
