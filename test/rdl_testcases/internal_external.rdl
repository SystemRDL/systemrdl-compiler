
addrmap extern_test {
    reg rega_t {field {} x;} external reg1, reg2;
    reg regb_t {field {} x;} internal reg3, reg4;
    reg regc_t {field {} x;} reg5;
    reg reg_t {field {} x;};
    reg {field {} x;} external reg6;
    reg {field {} x;} external reg7;
    reg {field {} x;} reg8;
    external reg_t reg9;
    internal reg_t reg10;
    external reg { field {} x; } reg11;
    internal reg { field {} x; } reg12;

    regfile rfile1_t {
        external reg_t rega;
        internal reg_t regb;
        reg_t regc;
    };

    regfile rfile2_t {
        external rfile1_t rf1a;
        internal rfile1_t rf1b;
        rfile1_t rf1c;
    };

    external rfile1_t rf1a;
    internal rfile1_t rf1b;
    rfile1_t rf1c;

    external rfile2_t rf2a;
    internal rfile2_t rf2b;
    rfile2_t rf2c;
};