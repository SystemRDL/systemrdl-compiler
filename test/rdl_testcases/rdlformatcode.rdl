addrmap rdlformatcode {
    reg reg_t {
        field {} f;
    };
    
    reg_t r0, r1, r2, r3, r4, r5, r6, r7, r8, r9, r10, r11, r12, r13, r14;
    
    r0->desc = "[p]asdf[/p]";
    r1->desc = "[b]asdf[/b]";
    r2->desc = "[i]asdf[/i]";
    r3->desc = "[u]asdf[/u]";
    r4->desc = "[color=red]asdf[/color]";
    r5->desc = "[size=12]asdf[/size]";
    r6->desc = "[url]github.com[/url]";
    r7->desc = "[url=github.com]asdf[/url]";
    r8->desc = "[email]asdf@example.com[/email]";
    r9->desc = "[img]image.png[/img]";
    r10->desc = "[code]asdf[/code]";
    r11->desc = "[quote]asdf[/quote]";
    r12->desc = "[br][lb][rb][sp]";
    r13->desc = "[name]";
    r14->desc = "[instname]";
    
    reg_t r15[3];
    r15->desc = "[index]";
    r15.f->desc = "[index_parent]";

    reg_t r16, r17, r18, r19;
    r16->desc = "";
    r17->desc = "
    ";
    r18->desc = "[list][*]a[*]b[*]c[/list]";
    r19->desc = "[list=a][*]a[*]b[*]c[/list]";
};