
enum my_enum {
    zero;
    one;
    two = 2;
    three = 3 {
        
    };
    four {};
    five {
        desc = "five";
        name = "this is five";
    };
};



reg my_reg #(
    bit MY_PARAM = 1,
    my_enum FOO = my_enum::four
) {
    field my_field {
        hw = rw;
        sw = rw;
        reset = 1 + 3;
    };
    
    
    my_field asdf[2] = 1;
    my_field yay = 1;
    my_field foo = 1 / MY_PARAM + 0x100 - 16'd4;
    
    foo->reset = FOO - 4;
    
};


property my_super_udp {
    component = all;
    type = ref;
};

addrmap my_design {
    my_reg reg_a[2];
    my_reg reg_b[3][2];
    my_reg #(
        .MY_PARAM(2),
        .FOO(my_enum::five)
    ) reg_c;
    
    reg_b->ispresent=false;
    
    signal {} sig_a;
    
    reg {
        field {} \field;
        field {} f_a;
        field {} f_b[31:2];
    } r_a[3];
    
    my_super_udp = r_a[1];
};

